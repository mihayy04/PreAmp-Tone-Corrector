** Profile: "SCHEMATIC1-sim 1"  [ c:\facultate\proiect apd orcad\p1_2025_433a_ispas_mihai_dumitru_pact_n4_orcad\schematics\ispas_mihai_orcad-pspicefiles\schematic1\sim 1.sim ]

** Creating circuit file "sim 1.cir"
** WARNING: THIS AUTOMATICALLY GENERATED FILE MAY BE OVERWRITTEN BY SUBSEQUENT SIMULATIONS

*Libraries:
* Profile Libraries :
* Local Libraries :
* From [PSPICE NETLIST] section of C:\Users\mikey\AppData\Roaming\SPB_Data\cdssetup\OrCAD_PSpice\25.1.0\PSpice.ini file:
.lib "nom.lib"

*Analysis directives:
.AC DEC 1k 1 100meg
.OPTIONS ADVCONV
.PROBE64 V(alias(*)) I(alias(*)) W(alias(*)) D(alias(*)) NOISE(alias(*))
.INC "..\SCHEMATIC1.net"

.END
